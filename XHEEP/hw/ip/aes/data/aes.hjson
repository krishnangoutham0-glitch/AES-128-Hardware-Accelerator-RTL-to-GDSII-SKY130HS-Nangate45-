// Copyright EPFL and Politecnico di Torino contributors.
// Licensed under the Apache License, Version 2.0, see LICENSE for details.
// SPDX-License-Identifier: Apache-2.0

{
  name: "aes"
  clock_primary: "clk_i"

  bus_interfaces: [
    {
      protocol: "reg_iface"
      direction: "device"
    }
  ]

  regwidth: "32"

  registers: [

    // ------------------------------------------------------------
    // PLAINTEXT REGISTERS
    // AES plaintext is 128 bits, accessed as four 32-bit words.
    // ------------------------------------------------------------

    {
      name: "PLAINTEXT_0"
      desc: "Plaintext bits [127:96]"
      swaccess: "rw"
      hwaccess: "hro"

      fields: [
        {
          bits: "31:0"
          name: "DATA"
          desc: "Plaintext word 0"
        }
      ]
    }

    {
      name: "PLAINTEXT_1"
      desc: "Plaintext bits [95:64]"
      swaccess: "rw"
      hwaccess: "hro"

      fields: [
        {
          bits: "31:0"
          name: "DATA"
          desc: "Plaintext word 1"
        }
      ]
    }

    {
      name: "PLAINTEXT_2"
      desc: "Plaintext bits [63:32]"
      swaccess: "rw"
      hwaccess: "hro"

      fields: [
        {
          bits: "31:0"
          name: "DATA"
          desc: "Plaintext word 2"
        }
      ]
    }

    {
      name: "PLAINTEXT_3"
      desc: "Plaintext bits [31:0]"
      swaccess: "rw"
      hwaccess: "hro"

      fields: [
        {
          bits: "31:0"
          name: "DATA"
          desc: "Plaintext word 3"
        }
      ]
    }


    // ------------------------------------------------------------
    // KEY REGISTERS
    // AES-128 key is 128 bits, accessed as four 32-bit words.
    // ------------------------------------------------------------

    {
      name: "KEY_0"
      desc: "AES key bits [127:96]"
      swaccess: "rw"
      hwaccess: "hro"

      fields: [
        {
          bits: "31:0"
          name: "DATA"
          desc: "Key word 0"
        }
      ]
    }

    {
      name: "KEY_1"
      desc: "AES key bits [95:64]"
      swaccess: "rw"
      hwaccess: "hro"

      fields: [
        {
          bits: "31:0"
          name: "DATA"
          desc: "Key word 1"
        }
      ]
    }

    {
      name: "KEY_2"
      desc: "AES key bits [63:32]"
      swaccess: "rw"
      hwaccess: "hro"

      fields: [
        {
          bits: "31:0"
          name: "DATA"
          desc: "Key word 2"
        }
      ]
    }

    {
      name: "KEY_3"
      desc: "AES key bits [31:0]"
      swaccess: "rw"
      hwaccess: "hro"

      fields: [
        {
          bits: "31:0"
          name: "DATA"
          desc: "Key word 3"
        }
      ]
    }

// ------------------------------------------------------------
// CONTROL REGISTER
// ------------------------------------------------------------

{
  name: "CONTROL"
  desc: "AES accelerator control register"
  swaccess: "rw"
  hwaccess: "hro"

  hwqe: "true"

  fields: [
    {
      bits: "0"
      name: "START"
      desc: "Start AES encryption"
    }
  ]
}

    // ------------------------------------------------------------
    // STATUS REGISTER
    //
    // These values are generated by the AES hardware.
    // ------------------------------------------------------------

    {
      name: "STATUS"
      desc: "AES accelerator status register"
      swaccess: "ro"
      hwaccess: "hrw"

      fields: [
        {
          bits: "0"
          name: "BUSY"
          desc: "AES accelerator is currently processing"
        }

        {
          bits: "1"
          name: "DONE"
          desc: "AES encryption operation has completed"
        }
      ]
    }


    // ------------------------------------------------------------
    // CIPHERTEXT REGISTERS
    // AES output is 128 bits, exposed as four 32-bit words.
    // ------------------------------------------------------------

    {
      name: "CIPHERTEXT_0"
      desc: "Ciphertext bits [127:96]"
      swaccess: "ro"
      hwaccess: "hrw"

      fields: [
        {
          bits: "31:0"
          name: "DATA"
          desc: "Ciphertext word 0"
        }
      ]
    }

    {
      name: "CIPHERTEXT_1"
      desc: "Ciphertext bits [95:64]"
      swaccess: "ro"
      hwaccess: "hrw"

      fields: [
        {
          bits: "31:0"
          name: "DATA"
          desc: "Ciphertext word 1"
        }
      ]
    }

    {
      name: "CIPHERTEXT_2"
      desc: "Ciphertext bits [63:32]"
      swaccess: "ro"
      hwaccess: "hrw"

      fields: [
        {
          bits: "31:0"
          name: "DATA"
          desc: "Ciphertext word 2"
        }
      ]
    }

    {
      name: "CIPHERTEXT_3"
      desc: "Ciphertext bits [31:0]"
      swaccess: "ro"
      hwaccess: "hrw"

      fields: [
        {
          bits: "31:0"
          name: "DATA"
          desc: "Ciphertext word 3"
        }
      ]
    }

  ]
}
